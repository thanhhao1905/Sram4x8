** sch_path: /home/thanhhao/Desktop/Lab_31/Lab_31.2/xschem/Sram_6T_bitcell.sch
.subckt Sram_6T_bitcell WL Q BLB QB BL

XM1 Q QB GND GND sky130_fd_pr__nfet_01v8 L=0.15 W=0.5 nf=1
XM2 QB Q VDD VDD sky130_fd_pr__pfet_01v8 L=0.15 W=1 nf=1
XM3 Q QB VDD VDD sky130_fd_pr__pfet_01v8 L=0.15 W=1 nf=1
XM4 QB Q GND GND sky130_fd_pr__nfet_01v8 L=0.15 W=0.5 nf=1
XM5 BL WL Q GND sky130_fd_pr__nfet_01v8 L=0.15 W=0.5 nf=1
XM6 BLB WL QB GND sky130_fd_pr__nfet_01v8 L=0.15 W=0.5 nf=1

.GLOBAL VDD
.GLOBAL GND
.end
