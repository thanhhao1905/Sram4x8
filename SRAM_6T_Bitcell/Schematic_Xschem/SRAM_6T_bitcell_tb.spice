name=spice_SRAM_tb only_toplevel=false value=".lib /home/thanhhao/.ciel/ciel/sky130/versions/0fe599b2afb6708d281543108caf8310912f54af/sky130A/libs.tech/ngspice/sky130.lib.spice tt

VVDD VDD 0  1.8
VVGND  VGND  0  0

Vin1 WL GND DC 0 pulse(0   1.8   0n  100p  100p  10n     20n)
Vin2 BL GND DC 0 pulse(0   1.8   0n  100p  100p  4.5n    10n)
Vin3 BLB GND DC 0 pulse(0  1.8   5n  100p  100p  4.5n    10n)

CBL   BL  0  20f
CBLB  BLB 0  20f

.ic V(x1.Q)=1.8 V(x1.QB)=0

.tran 10p 100n

.control
run
plot v(Q) v(QB)+2 v(WL)+4 v(BL)+6 v(BLB)+8
.endc
.end"
