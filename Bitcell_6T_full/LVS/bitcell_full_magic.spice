* NGSPICE file created from bitcell_full.ext - technology: sky130A

.subckt bitcell_full WL Q BLB QB BL pre_charge sense write data_in read data_out VDD
+ VDD2 GND
X0 QB Q GND GND sky130_fd_pr__nfet_01v8 ad=0.15 pd=1.1 as=0.1625 ps=1.15 w=0.5 l=0.15
X1 data_out a_175_295# BL VDD sky130_fd_pr__pfet_01v8 ad=0.6 pd=3.2 as=0.6 ps=3.2 w=1 l=0.15
X2 BLB BL a_185_945# VDD sky130_fd_pr__pfet_01v8 ad=1.1 pd=5.1 as=0.6 ps=2.6 w=2 l=0.15
X3 BLB BL a_185_705# GND sky130_fd_pr__nfet_01v8 ad=0.6 pd=3.2 as=0.3 ps=1.6 w=1 l=0.15
X4 BL write data_in GND sky130_fd_pr__nfet_01v8 ad=0.15 pd=1.1 as=0.275 ps=2.1 w=0.5 l=0.15
X5 VDD2 pre_charge BL GND sky130_fd_pr__nfet_01v8 ad=0.3 pd=2.2 as=0.275 ps=2.1 w=0.5 l=0.15
X6 a_185_945# a_40_705# VDD VDD sky130_fd_pr__pfet_01v8 ad=1.2 pd=5.2 as=0.6 ps=2.6 w=2 l=0.15
X7 data_out read BL GND sky130_fd_pr__nfet_01v8 ad=0.3 pd=2.2 as=0.15 ps=1.1 w=0.5 l=0.15
X8 VDD sense a_40_705# VDD sky130_fd_pr__pfet_01v8 ad=0.6 pd=2.6 as=1.1 ps=5.1 w=2 l=0.15
X9 a_185_705# sense GND GND sky130_fd_pr__nfet_01v8 ad=0.6 pd=3.2 as=0.6 ps=3.2 w=1 l=0.15
X10 GND sense a_40_705# GND sky130_fd_pr__nfet_01v8 ad=0.6 pd=3.2 as=0.55 ps=3.1 w=1 l=0.15
X11 BLB WL QB GND sky130_fd_pr__nfet_01v8 ad=0.275 pd=2.1 as=0.15 ps=1.1 w=0.5 l=0.15
X12 VDD QB Q VDD sky130_fd_pr__pfet_01v8 ad=0.325 pd=1.65 as=0.55 ps=3.1 w=1 l=0.15
X13 BLB pre_charge BL GND sky130_fd_pr__nfet_01v8 ad=0.3 pd=2.2 as=0.3 ps=2.2 w=0.5 l=0.15
X14 a_175_295# read VDD VDD sky130_fd_pr__pfet_01v8 ad=0.55 pd=3.1 as=0.6 ps=3.2 w=1 l=0.15
X15 GND QB Q GND sky130_fd_pr__nfet_01v8 ad=0.1625 pd=1.15 as=0.15 ps=1.1 w=0.5 l=0.15
X16 a_185_945# BLB BL VDD sky130_fd_pr__pfet_01v8 ad=0.6 pd=2.6 as=1.2 ps=5.2 w=2 l=0.15
X17 a_175_295# read GND GND sky130_fd_pr__nfet_01v8 ad=0.275 pd=2.1 as=0.3 ps=2.2 w=0.5 l=0.15
X18 Q WL BL GND sky130_fd_pr__nfet_01v8 ad=0.15 pd=1.1 as=0.35 ps=2.4 w=0.5 l=0.15
X19 a_185_705# BLB BL GND sky130_fd_pr__nfet_01v8 ad=0.3 pd=1.6 as=0.6 ps=3.2 w=1 l=0.15
X20 QB Q VDD VDD sky130_fd_pr__pfet_01v8 ad=0.6 pd=3.2 as=0.325 ps=1.65 w=1 l=0.15
X21 BLB pre_charge VDD2 GND sky130_fd_pr__nfet_01v8 ad=0.35 pd=2.4 as=0.3 ps=2.2 w=0.5 l=0.15
.ends
