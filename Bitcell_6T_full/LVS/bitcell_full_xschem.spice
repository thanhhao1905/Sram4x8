** sch_path: /home/thanhhao/Desktop/Lab_31/Lab_31.3.1/bitcell_6t_full.sch
.subckt bitcell_full WL Q BLB QB BL pre_charge sense write data_in read data_out
XM1 Q QB GND GND sky130_fd_pr__nfet_01v8 L=0.15 W=0.5 nf=1
XM2 QB Q VDD VDD sky130_fd_pr__pfet_01v8 L=0.15 W=1 nf=1
XM3 Q QB VDD VDD sky130_fd_pr__pfet_01v8 L=0.15 W=1 nf=1
XM4 QB Q GND GND sky130_fd_pr__nfet_01v8 L=0.15 W=0.5 nf=1
XM5 BL WL Q GND sky130_fd_pr__nfet_01v8 L=0.15 W=0.5 nf=1
XM6 BLB WL QB GND sky130_fd_pr__nfet_01v8 L=0.15 W=0.5 nf=1
XM7 BLB pre_charge BL GND sky130_fd_pr__nfet_01v8 L=0.15 W=0.5 nf=1
XM8 BL pre_charge VDD2 GND sky130_fd_pr__nfet_01v8 L=0.15 W=0.5 nf=1
XM9 BLB pre_charge VDD2 GND sky130_fd_pr__nfet_01v8 L=0.15 W=0.5 nf=1
XM10 BLB BL net2 VDD sky130_fd_pr__pfet_01v8 L=0.15 W=2 nf=1
XM11 BLB BL net1 GND sky130_fd_pr__nfet_01v8 L=0.15 W=1 nf=1
XM12 BL BLB net2 VDD sky130_fd_pr__pfet_01v8 L=0.15 W=2 nf=1
XM13 BL BLB net1 GND sky130_fd_pr__nfet_01v8 L=0.15 W=1 nf=1
XM14 net3 sense VDD VDD sky130_fd_pr__pfet_01v8 L=0.15 W=2 nf=1
XM15 net3 sense GND GND sky130_fd_pr__nfet_01v8 L=0.15 W=1 nf=1
XM16 net2 net3 VDD VDD sky130_fd_pr__pfet_01v8 L=0.15 W=2 nf=1
XM17 net1 sense GND GND sky130_fd_pr__nfet_01v8 L=0.15 W=1 nf=1
XM18 BL write data_in GND sky130_fd_pr__nfet_01v8 L=0.15 W=0.5 nf=1
XM19 BL read data_out GND sky130_fd_pr__nfet_01v8 L=0.15 W=0.5 nf=1
XM20 data_out net4 BL VDD sky130_fd_pr__pfet_01v8 L=0.15 W=1 nf=1
XM21 net4 read VDD VDD sky130_fd_pr__pfet_01v8 L=0.15 W=1 nf=1
XM22 net4 read GND GND sky130_fd_pr__nfet_01v8 L=0.15 W=0.5 nf=1

.GLOBAL VDD
.GLOBAL GND
.GLOBAL VDD2
.end
